* A3 empty design skeleton. No passing solution is supplied.
.subckt capless_ldo vin vout vss vref
* TODO: Design the PMOS pass stage, amplifier, bias, reference buffer and feedback.
.ends capless_ldo
