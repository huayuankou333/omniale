* A4 empty design skeleton. No passing solution is supplied.
.subckt sampling_feedback_ota vss iref vdd vinn vinp vocm voutn voutp
* TODO: Design OTA and continuous common-mode feedback.
.ends sampling_feedback_ota
.subckt sensor_interface vss vdd sensn sensp vocm drvn drvp
* TODO: Design sensor buffers / isolation / bias from vdd.
.ends sensor_interface
