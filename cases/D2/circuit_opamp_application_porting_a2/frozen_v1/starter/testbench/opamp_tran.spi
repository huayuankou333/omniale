* Follower step-response testbench (from tb_Opamp_2stg_tran): VCM +/- Vstep/2 pulse, period T.
* DUT: .subckt dut iref inp inn out.
.lib /opt/sky130/continuous/sky130.lib.spice tt
.param VDD=1.2 Iref=20u
.global vdd
.options reltol=1e-3 gmin=1e-12 vntol=1e-6 abstol=1e-12
.temp 27

.include /app/circuit.spi

VSUP vdd 0 dc {VDD}
.param VCM=0.9 CL=1p Vstep=0.2 T=100n td=5n tr=10p
IREF vdd niref dc {Iref}
VIN nin 0 dc {VCM-Vstep/2} PULSE({VCM-Vstep/2} {VCM+Vstep/2} {td} {tr} {tr} {T/2-tr} {T})
XDUT niref nin nout nout dut
CL nout 0 {CL}

.control
set wr_singlescale
set wr_vecnames
option numdgt=7
tran 10p 200n 0 10p
wrdata tran.txt v(nin) v(nout) i(VSUP)
.endc
.end
