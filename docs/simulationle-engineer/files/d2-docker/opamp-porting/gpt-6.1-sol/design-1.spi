.subckt dut iref inp inn out
* Mirrored reference and low-headroom current sinks
Xref iref iref 0 0 sky130_fd_pr__nfet_01v8_lvt W=20 L=1 nf=1 m=1
Xtail tail iref 0 0 sky130_fd_pr__nfet_01v8_lvt W=60 L=1 nf=1 m=1
* Differential first stage and active mirror
Xip n1 inn tail 0 sky130_fd_pr__nfet_01v8_lvt W=90 L=1.2 nf=1 m=1
Xin n2 inp tail 0 sky130_fd_pr__nfet_01v8_lvt W=90 L=1.2 nf=1 m=1
Xp1 n1 n1 vdd vdd sky130_fd_pr__pfet_01v8_lvt W=30 L=1.2 nf=1 m=1
Xp2 n2 n1 vdd vdd sky130_fd_pr__pfet_01v8_lvt W=30 L=1.2 nf=1 m=1
* Common-source output stage
Xpo out n2 vdd vdd sky130_fd_pr__pfet_01v8_lvt W=140 L=0.7 nf=1 m=1
Xno out iref 0 0 sky130_fd_pr__nfet_01v8_lvt W=150 L=1 nf=1 m=1
Rc n2 nc 1.2k
Cc nc out 0.65p
.ends dut
