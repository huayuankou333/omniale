* Generated from agent-authored design.json; no topology supplied by compiler.
.subckt capless_ldo vin vout vss vref
XBIAS pbias pbias vin vin sky130_fd_pr__pfet_01v8 w=10 l=2 nf=1 m=1
RBIAS pbias vref 50k
XTAIL tail pbias vin vin sky130_fd_pr__pfet_01v8 w=30 l=2 nf=1 m=1
XINFB mirror fb tail vin sky130_fd_pr__pfet_01v8 w=100 l=1 nf=1 m=1
XINREF gate vref tail vin sky130_fd_pr__pfet_01v8 w=100 l=1 nf=1 m=1
XMIRROR mirror mirror vss vss sky130_fd_pr__nfet_01v8 w=10 l=2 nf=1 m=1
XSINK gate mirror vss vss sky130_fd_pr__nfet_01v8 w=10 l=2 nf=1 m=1
XPASS vout gate vin vin sky130_fd_pr__pfet_01v8 w=6000 l=0.5 nf=100 m=1
RZERO gate comp 100
CMILLER comp vout 30p
COUT vout vss 900p
RUPPER vout fb 150k
RLOWER fb vss 100k
.ends capless_ldo
