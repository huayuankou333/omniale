** sch_path: D:/LINK/SimulationLE/case/D2/circuit_ldo/runs_feedback3/20261106_125440/gpt-6.1-sol/turn_003/candidate/asset/capless_ldo.sch
.subckt capless_ldo vin vout vss vref
*.PININFO vin:B vout:B vss:B vref:B
XBIAS pbias pbias vin vin sky130_fd_pr__pfet_01v8 w=10 l=2 nf=1 m=1
RBIAS pbias vref 50k m=1
XTAIL tail pbias vin vin sky130_fd_pr__pfet_01v8 w=150 l=2 nf=1 m=1
XINFB mirror fb tail vin sky130_fd_pr__pfet_01v8_lvt w=100 l=1 nf=1 m=1
XINREF gate vref tail vin sky130_fd_pr__pfet_01v8_lvt w=100 l=1 nf=1 m=1
XMIRROR mirror mirror vss vss sky130_fd_pr__nfet_01v8 w=20 l=2 nf=1 m=1
XSINK gate mirror vss vss sky130_fd_pr__nfet_01v8 w=20 l=2 nf=1 m=1
XPASS vout gate vin vin sky130_fd_pr__pfet_01v8 w=30 l=0.5 nf=1 m=200
CTRACK vin gate 160p m=1
RZERO gate comp 1k m=1
CMILLER comp vout 3p m=1
COUT vout vss 830p m=1
RUPPER vout fb 150k m=1
RLOWER fb vss 100k m=1
.ends
