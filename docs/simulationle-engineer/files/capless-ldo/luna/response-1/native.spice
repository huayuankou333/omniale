** sch_path: D:/LINK/SimulationLE/case/D2/circuit_ldo/runs_feedback3/20261106_125440/gpt-6-luna/turn_001/candidate/asset/capless_ldo.sch
.subckt capless_ldo vin vout vss vref
*.PININFO vin:B vout:B vss:B vref:B
XPASS vout drive vin vin sky130_fd_pr__pfet_01v8 w=1200 l=1 nf=20 m=1
RBIAS vin bias 100k m=1
XBIAS bias bias vss vss sky130_fd_pr__nfet_01v8 w=10 l=1 nf=1 m=1
XAMP drive fb vin vin sky130_fd_pr__pfet_01v8 w=20 l=1 nf=2 m=1
XLOAD drive bias vss vss sky130_fd_pr__nfet_01v8 w=10 l=1 nf=1 m=1
RFTOP vout fb 150k m=1
RFBOT fb vss 100k m=1
COUT vout vss 800p m=1
CCOMP drive vss 100p m=1
.ends
