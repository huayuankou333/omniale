* Generated from agent-authored design.json; no topology supplied by compiler.
.subckt capless_ldo vin vout vss vref
XPASS vout drive vin vin sky130_fd_pr__pfet_01v8 w=100 l=1 nf=20 m=1
RBIAS vin bias 100k
XBIAS bias bias vss vss sky130_fd_pr__nfet_01v8 w=8 l=1 nf=1 m=1
XTAIL tail bias vss vss sky130_fd_pr__nfet_01v8 w=8 l=1 nf=1 m=1
XINP left fb tail vss sky130_fd_pr__nfet_01v8 w=12 l=1 nf=1 m=1
XINM drive vref tail vss sky130_fd_pr__nfet_01v8 w=12 l=1 nf=1 m=1
XMP1 left left vin vin sky130_fd_pr__pfet_01v8 w=12 l=1 nf=1 m=1
XMP2 drive left vin vin sky130_fd_pr__pfet_01v8 w=12 l=1 nf=1 m=1
RFTOP vout fb 150k
RFBOT fb vss 100k
COUT vout vss 800p
CCOMP drive vss 100p
RDRIVE vin drive 1meg
.ends capless_ldo
