** sch_path: D:/LINK/SimulationLE/case/D2/circuit_ldo/runs_feedback3/20261106_125440/gpt-6-luna/turn_003/candidate/asset/capless_ldo.sch
.subckt capless_ldo vin vout vss vref
*.PININFO vin:B vout:B vss:B vref:B
XPASS vout drive vin vin sky130_fd_pr__pfet_01v8 w=100 l=1 nf=20 m=1
RBIAS vin bias 100k m=1
XBIAS bias bias vss vss sky130_fd_pr__nfet_01v8 w=8 l=1 nf=1 m=1
XTAIL tail bias vss vss sky130_fd_pr__nfet_01v8 w=8 l=1 nf=1 m=1
XINP left fb tail vss sky130_fd_pr__nfet_01v8 w=12 l=1 nf=1 m=1
XINM drive vref tail vss sky130_fd_pr__nfet_01v8 w=12 l=1 nf=1 m=1
XMP1 left left vin vin sky130_fd_pr__pfet_01v8 w=12 l=1 nf=1 m=1
XMP2 drive left vin vin sky130_fd_pr__pfet_01v8 w=12 l=1 nf=1 m=1
RFTOP vout fb 150k m=1
RFBOT fb vss 100k m=1
COUT vout vss 800p m=1
CCOMP drive vss 100p m=1
RDRIVE vin drive 1meg m=1
.ends
